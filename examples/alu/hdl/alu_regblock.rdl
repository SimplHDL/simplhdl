enum operation_e {
    nop = 0 { desc = "No operation"; };
    add = 1 { desc = "Addition"; };
    sub = 2 { desc = "Substraction"; };
};

addrmap alu_regblock {

    reg {
        desc = "Control register";
        field {
            desc = "Select ALU operation";
            sw = rw;
            hw = r;
        } operation;
    } CTRL;

    reg {
        desc = "Input register A";
        field {
            desc = "Value of register";
            sw = rw;
            hw = r;
        } value[7:0] = 0;
    } A;

    reg {
        desc = "Input register B";
        field {
            desc = "Value of register";
            sw = rw;
            hw = r;
        } value[7:0] = 0;
    } B;

    reg {
        field {
            desc = "Value of register";
            sw = r;
            hw = w;
        } value[7:0];
    } RESULT;
};
